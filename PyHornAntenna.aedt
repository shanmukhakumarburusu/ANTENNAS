# Ansys Electronics Desktop project, version 2021.1
materials:
  vacuum: permittivity=1
  copper: permeability=0.999991 conductivity=58000000

design HFSSDesign1 (HFSS, DrivenModal, model units mm)
options: Calculate_Lossy_Dielectrics Save_Adaptive_support_files
variables:
  wg_length = 5mm
  b = 9.525mm
  a = 19.05mm
  rr = a/1.5
  sb = 9.525mm
  sa = 14.31mm
  t = 0.5mm
  h_cone = 5.36mm
  hh = 16mm
  r_bottom_cone = 39.5mm
  r_top_cone = 25mm
  th_cone = 0.1mm
  cone_gap = 5mm
  r4 = 45mm
  dist_z = 1mm
  gh = 10mm
  ct = 39.5mm
  cb = rr
  cth = 0.1mm
  h_fl = 80mm
  sa_f = 80mm
  sb_f = 40mm
  arad = sa_f+2*t+4mm
  brad = sb_f+2*t+4mm
  hrad = wg_length+h_fl+10mm
geometry:
  inner = box(corner=(-a/2, -b/2, 0mm), size=(a, b, wg_length))
  waveguide [copper], Box1_ObjectFromFace2, Box1_ObjectFromFace3, Box1_ObjectFromFace4 = object_from(inner.face(-y, -x, +y, +x))
  inner.delete()
  waveguide.unite(Box1_ObjectFromFace2, Box1_ObjectFromFace3, Box1_ObjectFromFace4)
  waveguide.thicken(t)
  Line_X = polyline((-sa_f/2, 0mm, wg_length+t+h_fl+1mm) (sa_f/2, 0mm, wg_length+t+h_fl+1mm))
  line_Y = polyline((0mm, -sb_f/2, wg_length+t+h_fl+1mm) (0mm, sb_f/2, wg_length+t+h_fl+1mm))
  plate [copper] = rectangle(corner=(-a/2, -b/2, 0), x_size=a, y_size=b)
  plate.thicken(t)
  horn [copper] = rectangle(corner=(-a/2-t, -b/2-t, wg_length), x_size=a+2*t, y_size=b+2*t)
  PyH_front = rectangle(corner=(-sa_f/2-t, -sb_f/2-t, wg_length+h_fl), x_size=sa_f+2*t, y_size=sb_f+2*t)
  horn.connect(PyH_front)
  PyH1 = rectangle(corner=(-a/2, -b/2, wg_length), x_size=a, y_size=b)
  PyH_front1 = rectangle(corner=(-sa_f/2, -sb_f/2, wg_length+h_fl), x_size=sa_f, y_size=sb_f)
  PyH1.connect(PyH_front1)
  horn.subtract(PyH1)
  radbox [vacuum] = box(corner=(-arad/2, -brad/2, 0mm), size=(arad, brad, hrad))
boundaries and excitations:
  Rad1: Radiation Objects=radbox
  1: Wave Port Faces=plate.face(at (0, 0, 0.5)) NumModes=1 Modes{Mode1{IntLine{middle of plate.edge(at (0, -4.7625, 0.5)) -> plate.face(at (0, 0, 0.5))} CharImp=Zpi}}
setups:
  Setup1: HfssDriven Frequency=14GHz MaxDeltaS=0.02 MaximumPasses=15 MinimumPasses=1 MinimumConvergedPasses=1 PercentRefinement=30 BasisOrder=1 PortAccuracy=2
    sweep Sweep: 8GHz to 24GHz step 0.01GHz; Type=Fast SaveFields
source amplitudes:
  1:1: 1W 0deg
radiation setups:
  Infinite Sphere1: Infinite Sphere Theta=-180deg..180deg step 5deg Phi=0deg..360deg step 5deg
reports:
  XY Plot 1: dB(S(1,1)) vs Freq on Setup1 : Sweep [sb_f=all]; markers m1 at 10.81GHz
  3D Polar Plot 1: dB(GainTotal) vs Phi, Theta on Setup1 : Sweep, Infinite Sphere1 [Freq=14GHz]
  XY Plot 2: dB(GainPhi), dB(GainTheta) vs Theta on Setup1 : LastAdaptive, Infinite Sphere1 [Phi=0deg,90deg Freq=14GHz]; markers m1 at 0deg, m2 at -180deg, m3 at -25deg, m4 at -25deg
  XY Plot 6: dB(GainPhi), dB(GainTheta) vs Theta on Setup1 : LastAdaptive, Infinite Sphere1 [Phi=0deg,90deg Freq=14GHz sb_f=all]
  Gain Plot 1: GainTotal vs Phi, Theta on Setup1 : LastAdaptive, Infinite Sphere1 [Freq=14GHz]
