# Ansys Electronics Desktop project, version 2021.1
materials:
  vacuum: permittivity=1

design HFSSDesign1 (HFSS, DrivenModal, model units mm)
geometry:
  waveguide [vacuum] = box(corner=((-92/2) mm, (-46/2) mm, 0mm), size=(92mm, 46mm, 104mm))
  Rectangle1 = rectangle(corner=((201/2) mm, (134/2) mm, 163.8mm), x_size=-201mm, y_size=-134mm)
  Rectangle1_ObjectFromFace1 = object_from(Rectangle1.face(at (0, 0, 163.8)))
  Box1_ObjectFromFace1 = object_from(waveguide.face(+z))
  Rectangle1_ObjectFromFace1.connect(Box1_ObjectFromFace1)
  Rectangle1_ObjectFromFace1.uncover_faces(FacesToUncover=waveguide.face(1 of 1))
  Rectangle1.uncover_faces(FacesToUncover=Rectangle1.face(at (0, 0, 163.8)))
  Rectangle1_ObjectFromFace1.uncover_faces(FacesToUncover=Box1_ObjectFromFace1.face)
  waveguide.uncover_faces(FacesToUncover=waveguide.face(+z))
  waveguide.unite(Rectangle1_ObjectFromFace1)
  Box1 [vacuum] = box(corner=((-250/2) mm, -100mm, 0mm), size=(250mm, 200mm, 200mm))
boundaries and excitations:
  PerfE1: Perfect E Faces=waveguide.face(+y, -y, +x, -x, #214, #213, #216, #215)
  Rad1: Radiation Objects=Box1
  1: Wave Port Faces=waveguide.face(-z) NumModes=1 Modes{Mode1{IntLine{middle of waveguide.edge(7 of 12) -> middle of waveguide.edge(5 of 12)} CharImp=Zpi}}
setups:
  Setup1: HfssDriven Frequency=2.44GHz MaxDeltaS=0.02 MaximumPasses=10 MinimumPasses=1 MinimumConvergedPasses=1 PercentRefinement=30 BasisOrder=1 PortAccuracy=2
    sweep Sweep: 1.22GHz to 3.66GHz, 101 points; Type=Fast SaveFields
source amplitudes:
  1:1: 1W 0deg
radiation setups:
  Infinite Sphere1: Infinite Sphere Theta=-180deg..180deg step 10deg Phi=0deg..360deg step 10deg
reports:
  S Parameter Plot 1: dB(S(1,1)) vs Freq on Setup1 : Sweep; markers m1 at 1.8056GHz, m2 at 3.0012GHz, m3 at 3.2696GHz
  Gain Plot 1: GainTotal vs Phi, Theta on Setup1 : LastAdaptive, Infinite Sphere1 [Freq=2.44GHz]
  Gain Plot 2: GainTotal vs Theta on Setup1 : LastAdaptive, Infinite Sphere1 [Phi=all Freq=2.44GHz]
  VSWR Plot 1: VSWR(1) vs Freq on Setup1 : Sweep; markers m2 at 2.44GHz
