# Ansys Electronics Desktop project, version 2021.1
materials:
  vacuum: permittivity=1
  pec: conductivity=1e+30

design HFSSDesign1 (HFSS, DrivenModal, model units mm)
geometry:
  reflector [pec] = cylinder(axis=Z, base_centre=(0mm, 0mm, (-70/2) mm), radius=0.0625mm, height=70mm)
  dipole [pec] = cylinder(axis=Z, base_centre=(0mm, 43.75mm, 0.0625mm), radius=0.0625mm, height=31.19mm)
  dipole_1 [pec] = dipole.duplicate_around_axis(axis=Y, angle=180deg, total=2)
  reflector_1 [pec] = cylinder(axis=Z, base_centre=(0mm, 59.375mm, (-56.25/2) mm), radius=0.0625mm, height=56.25mm)
  port = rectangle(corner=(0mm, (43.75 -0.0625) mm, -0.0625mm), y_size=0.125mm, z_size=0.125mm)
  RadiatingSurface [vacuum] = region(absolute_offset=41.666667mm on all sides)
boundaries and excitations:
  Open1: Radiation Objects=RadiatingSurface
  1: Lumped Port Objects=port Modes{Mode1{IntLine{middle of port.edge(z at corner) -> middle of port.edge(z opposite corner)} CharImp=Zpi RenormImp=50ohm}} Impedance=50ohm
setups:
  Setup1: HfssDriven Frequency=2.4GHz MaxDeltaS=0.02 MaximumPasses=10 MinimumPasses=1 MinimumConvergedPasses=1 PercentRefinement=30 BasisOrder=1 PortAccuracy=2
    sweep Sweep: 1.2GHz to 3.6GHz, 101 points; Type=Interpolating SaveFields InterpTolerance=0.5 InterpMaxSolns=250 InterpUsePortImped=false PassivityErrorTolerance=0.0001
source amplitudes:
  1:1: 1W 0deg
radiation setups:
  3D: Infinite Sphere Theta=0deg..180deg step 2deg Phi=-180deg..180deg step 2deg
  Elevation: Infinite Sphere Theta=-180deg..180deg step 1deg Phi=0deg..90deg step 90deg
  Azimuth: Infinite Sphere Theta=90deg..90deg step 0deg Phi=-180deg..180deg step 1deg
reports:
  S Parameter Plot 1: dB(S(1,1)) vs Freq on Setup1 : Sweep; markers m1 at 2.352GHz, m2 at 1.872GHz, m3 at 2.184GHz, m4 at 2.448GHz
  Gain Plot 1: GainTotal vs Phi, Theta on Setup1 : LastAdaptive, 3D [Freq=2.4GHz]
  Gain Plot 2: GainTotal vs Theta on Setup1 : LastAdaptive, 3D [Phi=all Freq=2.4GHz]
  VSWR Plot 1: VSWR(1) vs Freq on Setup1 : Sweep; markers m1 at 2.4GHz
